// Design: playground/common_source
simulator lang=spectre
global 0
parameters nf={{nf}} nfin={{nfin}} r={{res}} vb={{vb}} VDD=0.9
include "/tools/gftech14/GF_PDK/14LPP-XL_V1.3.1.0/Models/Spectre/models/LN14LPP_Spectre.lib" section=tt

// playground/common_source/schematic
R0 (VDD out) resistor r=r
vVin (in VSS) vsource dc=vb mag=1 type=dc
vVSS (VSS 0) vsource dc=0 type=dc
vVDD (VDD VSS) vsource dc=VDD type=dc
N0 (out in VSS VSS) lvtnfet m=1 l=14n nfin=nfin nf=(nf)*(1) par_nf=(1)*((nf)*(1)) pdevdops=1 pdevlgeos=1 pdevwgeos=1 psw_acv_sign=1 plnest=1 pldist=1 cpp=78n fpitch=48n xpos=-99 ypos=-99 pre_layout_local=-1 ngcon=1 p_vta=0 u0mult_fet=1 lle_rxrxa=78n lle_rxrxb=78n lle_rxrxn=192n lle_rxrxs=192n lle_pcrxn=55n lle_pcrxs=55n lle_ctne=0 lle_ctnw=0 lle_ctse=0 lle_ctsw=0 lle_sctne=0 lle_sctnw=0 lle_sctse=0 lle_sctsw=0 dtemp=0 l_shape=0 l_shape_s=0 nsig_dop1=0 nsig_dop2=0 nsig_dibl=0 nsig_pc=0 nsig_rx=0 fc_index=0 fc_sigma=3
c0 (out VSS) capacitor c=20f
ac ac start=1 stop=2T dec=20
dcOp dc
